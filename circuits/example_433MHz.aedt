# Ansys Electronics Desktop project, version 2024.1
materials:
  copper: permeability=0.999991 conductivity=58000000
  FR4: permittivity=4.35 dielectric_loss_tangent=0.02

design Circuit1 (Circuit)
options: SParamCircuitDef IntegrationMethod=FFT
components:
  C1 = CAP_(C=c1)
  C2 = CAP_(C=c2)
  C3 = CAP_(C=c2)
  R12 = RES_(R=r1)
  A14 = IND_Q(L=l1 Q=Q)
  A1 = IND_Q(L=l1 Q=Q)
  A2 = IND_Q(L=lx Q=Q)
  C4 = CAP_(C=cx)
  C5 = CAP_(C=cx)
  port Port1 rz=50ohm iz=0ohm EnableNoise=false noisetemp=16.85cel
  port Port2 rz=50ohm iz=0ohm EnableNoise=false noisetemp=16.85cel
  port Port3 rz=50ohm iz=0ohm EnableNoise=false noisetemp=16.85cel
nets:
  0: C1.0, C2.1, C3.0, C4.0, C5.0
  net_5: C3.1, R12.0, A1.1, A2.0, C5.1
  Port1: C1.1, A14.0, A1.0
  Port2: C2.0, R12.1, A14.1
  Port3: A2.1, C4.1
setups:
  LinearFrequency: LinearFrequencyData(false, 0.1, false, "", false) SweepDefinition{Variable=Freq Data="LINC 100MHz 1000MHz 1001"}
reports:
  S Parameter Plot 1: dB(S(Port1,Port1)) vs Freq on LinearFrequency : LinearFrequency
  S Parameter Plot 2: dB(S(Port2,Port1)), dB(S(Port3,Port1)) vs Freq on LinearFrequency : LinearFrequency
  S Parameter Plot 3: cang_deg(S(Port2,Port1)/S(Port3,Port1)) vs Freq on LinearFrequency : LinearFrequency

design Circuit2 (Circuit)
options: SParamCircuitDef IntegrationMethod=FFT
components:
  C8 = CAP_(C=c1)
  L8 = IND_(L=l1)
  port Port1 rz=50ohm iz=0ohm EnableNoise=false noisetemp=16.85cel
  port Port2 rz=50ohm iz=0ohm EnableNoise=false noisetemp=16.85cel
nets:
  0: C8.0
  Port1: L8.0
  Port2: L8.1, C8.1
setups:
  LinearFrequency: LinearFrequencyData(false, 0.1, false, "", false) SweepDefinition{Variable=Freq Data="LINC 100MHz 1000MHz 201"}
reports:
  S Parameter Plot 1: cang_deg(S(Port1,Port1)) vs Freq on LinearFrequency : LinearFrequency; markers MX1 at x=4.33e+08

design rat_race_simple (Circuit)
options: SParamCircuitDef IntegrationMethod=FFT
components:
  L1 = IND_(L=L1)
  L2 = IND_(L=L1)
  L3 = IND_(L=L1)
  C1 = CAP_(C=C1)
  C2 = CAP_(C=2*C1)
  C3 = CAP_(C=2*C1)
  port Port1 rz=50ohm iz=0ohm EnableNoise=false noisetemp=16.85cel
  port Port2 rz=50ohm iz=0ohm EnableNoise=false noisetemp=16.85cel
  port Port3 rz=50ohm iz=0ohm EnableNoise=false noisetemp=16.85cel
  port Port4 rz=50ohm iz=0ohm EnableNoise=false noisetemp=16.85cel
nets:
  0: C2.1, C3.1
  Port1: L1.0, L2.1, C2.0
  Port2: L3.0, L1.1, C3.0
  Port3: L3.1, C1.1
  Port4: L2.0, C1.0
setups:
  LinearFrequency: LinearFrequencyData(false, 0.1, false, "", false) SweepDefinition{Variable=Freq Data="LINC 100MHz 1000MHz 201"}
reports:
  S Parameter Plot 1: dB(S(Port2,Port1)), dB(S(Port4,Port1)) vs Freq on LinearFrequency : LinearFrequency
  S Parameter Plot 2: im(S(Port2,Port1)/S(Port3,Port1)) vs Freq on LinearFrequency : LinearFrequency

design rat_race_1 (Circuit)
options: SParamCircuitDef IntegrationMethod=FFT
components:
  L1 = IND_(L=L1*k)
  L2 = IND_(L=L1*k)
  L3 = IND_(L=L1*k)
  C1 = CAP_(C=2*C1*k)
  C2 = CAP_(C=2*C1*k)
  C3 = CAP_(C=C2*k)
  C4 = CAP_(C=C2*k)
  L4 = IND_(L=L2/2*k)
  C5 = CAP_(C=C3*k)
  C6 = CAP_(C=C3*k)
  port Port1 rz=50ohm iz=0ohm EnableNoise=false noisetemp=16.85cel
  port Port2 rz=50ohm iz=0ohm EnableNoise=false noisetemp=16.85cel
  port Port3 rz=50ohm iz=0ohm EnableNoise=false noisetemp=16.85cel
  port Port4 rz=50ohm iz=0ohm EnableNoise=false noisetemp=16.85cel
nets:
  0: C5.1, C1.1, C2.1, C6.1, L4.0
  net_3: C3.0, L4.1, C4.1
  Port1: L2.1, C1.0, L1.0
  Port2: C5.0, L2.0, C3.1
  Port3: L3.0, L1.1, C2.0
  Port4: L3.1, C6.0, C4.0
setups:
  LinearFrequency: LinearFrequencyData(false, 0.1, false, "", false) SweepDefinition{Variable=Freq Data="LINC 100MHz 1000MHz 201"}
reports:
  S Parameter Plot 1: dB(S(Port1,Port1)), dB(S(Port4,Port1)) vs Freq on LinearFrequency : LinearFrequency; markers MX1 at x=4.33e+08
  S Parameter Plot 2: cang_deg(S(Port2,Port1)/S(Port3,Port1)) vs Freq on LinearFrequency : LinearFrequency
  S Parameter Plot 4: cang_deg(S(Port3,Port4)/S(Port2,Port4)) vs Freq on LinearFrequency : LinearFrequency; markers MX1 at x=2.2836653e+09
  S Parameter Plot 4_1: db(S(Port3,Port4)/S(Port2,Port4)) vs Freq on LinearFrequency : LinearFrequency; markers MX1 at x=2.2836653e+09

design rat_race_2 (Circuit)
options: SParamCircuitDef IntegrationMethod=FFT
components:
  C1 = CAP_(C=2*C1*k)
  C2 = CAP_(C=2*C1*k)
  C3 = CAP_(C=C2*k)
  C4 = CAP_(C=C2*k)
  C5 = CAP_(C=C3*k)
  C6 = CAP_(C=C3*k)
  A1 = IND_Q(L=L1*k Q=Q)
  A2 = IND_Q(L=L1*k Q=Q)
  A3 = IND_Q(L=L1*k Q=Q)
  A4 = IND_Q(L=L2/2*k Q=Q)
  port Port1 rz=50ohm iz=0ohm EnableNoise=false noisetemp=16.85cel
  port Port2 rz=50ohm iz=0ohm EnableNoise=false noisetemp=16.85cel
  port Port3 rz=50ohm iz=0ohm EnableNoise=false noisetemp=16.85cel
  port Port4 rz=50ohm iz=0ohm EnableNoise=false noisetemp=16.85cel
nets:
  0: A4.0, C1.1, C2.1, C5.1, C6.1
  net_3: A4.1, C3.0, C4.1
  Port1: A1.0, A2.1, C1.0
  Port2: A2.0, C3.1, C5.0
  Port3: A1.1, C2.0, A3.1
  Port4: C4.0, C6.0, A3.0
setups:
  LinearFrequency: LinearFrequencyData(false, 0.1, false, "", false) SweepDefinition{Variable=Freq Data="LINC 100MHz 1000MHz 201"}
optimetrics:
  ParametricSetup1: Parametric UseFastCalculationUpdateAlgo SaveSolutions Sim._Setups=[LinearFrequency]
    sweep Q: 15 1000000 30
reports:
  ReturnLoss: dB(S(Port4,Port4)) vs Freq on LinearFrequency : LinearFrequency [Q=all]; markers MX1 at x=4.33e+08
  PhaseDifference: cang_deg(S(Port3,Port4)/S(Port2,Port4)) vs Freq on LinearFrequency : LinearFrequency [Q=all]; markers MX1 at x=2.2836653e+09, MX2 at x=4.33e+08
  Isolation: dB(S(Port1,Port4)) vs Freq on LinearFrequency : LinearFrequency [Q=all]; markers MX1 at x=4.33e+08
  AmplitudeDifference: db(S(Port3,Port4)/S(Port2,Port4)) vs Freq on LinearFrequency : LinearFrequency [Q=all]; markers MX1 at x=2.2836653e+09, MX2 at x=4.33e+08
  InsertionLoss: 10*log10(mag(S(Port3,Port4))^2+mag(S(Port2,Port4))^2) vs Freq on LinearFrequency : LinearFrequency [Q=all]
